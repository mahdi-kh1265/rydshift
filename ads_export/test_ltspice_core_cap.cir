* LTspice Smoke Test: Core Capacitance Model
* This file tests the pure Maxwell capacitance matrix in LTspice.

.INCLUDE "eo_load_4node.sp"

* Excitation: 1V AC on +x, 0V on -x, +y, -y
V1 p_x_ext 0 AC 1 0
R1 p_x_ext p_x 50
R2 0 m_x 50
R3 0 p_y 50
R4 0 m_y 50

* Instantiate the core capacitive subcircuit
X1 p_x m_x p_y m_y EO_LOAD_4NODE

* AC Sweep from 0.5 MHz to 200 MHz
.AC LIN 400 0.5Meg 200Meg

* To run in LTspice, open this file and click Run.
* Check the current I(V1) to ensure the capacitive load draws the expected AC current.
.END
